* BlueSpice generated netlist
.title ac-current-divider
I1 0 isplit AC 1.0E-3 -90.0
R1 isplit 0 1000.0
R2 isplit 0 3000.0
.end
