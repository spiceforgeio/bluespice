* BlueSpice generated netlist
.title ac-voltage-divider
V1 vin 0 AC 10.0 90.0
R1 vin vmid 1000.0
R2 vmid 0 1000.0
.end
