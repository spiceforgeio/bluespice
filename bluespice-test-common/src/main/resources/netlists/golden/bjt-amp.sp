* BlueSpice generated netlist
.title bjt-amp
.model Q2N2222 NPN(IS=1.0E-14 BF=100.0 VAF=100.0)
VCC vcc 0 DC 12.0
VBIAS base 0 DC 1.2
RC vcc vout 4700.0
RE emitter 0 1000.0
Q1 vout base emitter Q2N2222
.end
