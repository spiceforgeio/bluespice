* BlueSpice generated netlist
.title diode-clamp
.model D1N4148 D(IS=2.52E-9 N=1.752 RS=0.568)
V1 vin 0 DC 5.0
R1 vin vclamped 1000.0
D1 vclamped 0 D1N4148
.end
