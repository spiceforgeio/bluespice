* BlueSpice generated netlist
.title rc-filter
V1 vin 0 DC 5.0
R1 vin vout 1000.0
C1 vout 0 1.0E-6
.end
