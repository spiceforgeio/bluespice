* BlueSpice generated netlist
.title rlc-series
V1 vin 0 DC 5.0
R1 vin n1 100.0
L1 n1 n2 1.0E-3
C1 n2 0 1.0E-6
.end
