* BlueSpice generated netlist
.title voltage-divider
V1 vin 0 DC 10.0
R1 vin vmid 1000.0
R2 vmid 0 1000.0
.end
